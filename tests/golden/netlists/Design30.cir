* Design30 (converted from Multisim)
vV1 1 0 dc 0 ac 1 0
+      distof1 0 0
+      distof2 0 0
+      sin(0 1 1000 0 0 0)

cC1 1 2 1u

cC2 5 4 0.015u

cC3 6 0 1u

rR1 VCC 3 100k vresR1
.model vresR1 r(  )

rR2 VCC 5 2.4k vresR2
.model vresR2 r(  )

rR3 3 0 17.4k vresR3
.model vresR3 r(  )

rR4 6 0 600k vresR4
.model vresR4 r(  )

xQ1 5 2 6 2N6038_ON

VCCVCC  VCC 0 dc 12

* scope XSC1
.SUBCKT 2N6038_ON 1 2 3
* Model generated on Feb 21, 2004
* Model format: PSpice
* Darlington macro model
* External node designations
* Node 1 -> Collect
* Node 2 -> Base
* Node 3 -> Emitter
Q1 1 2 4 qmodel
Q2 1 4 3 q1model 10.1541
D1 3 1 dmodel
R1 2 4 8000
R2 4 3 60
* Default values used in dmodel
*   EG=1.11 TT=0 BV=infinite
.MODEL dmodel d
+IS=1e-12 RS=9.92585 N=0.998898 XTI=2.9989
+CJO=0 VJ=0.75 M=0.33 FC=0.5
.MODEL qmodel npn
+IS=9.93107e-13 BF=98.923 NF=1.1336 VAF=91.0436
+IKF=0.174174 ISE=1.66132e-12 NE=1.57851 BR=0.9989
+NR=0.998916 VAR=92.663 IKR=0.099989 ISC=1e-13
+NC=1.9989 RB=9.92568 IRB=0.198899 RBM=9.92561
+RE=0.100034 RC=0.998278 XTB=0.498188 XTI=2.99897 EG=1.11183
+CJE=2.48923e-10 VJE=0.95 MJE=0.23 TF=1e-09
+XTF=1 VTF=10 ITF=0.01 CJC=4.25311e-11
+VJC=0.95 MJC=0.23 XCJC=0.9 FC=0.5
+TR=1e-07 PTF=0 KF=0 AF=1
.MODEL q1model npn
+IS=9.93107e-13 BF=98.923 NF=1.1336 VAF=91.0436
+IKF=0.174174 ISE=1.66132e-12 NE=1.57851 BR=0.9989
+NR=0.998916 VAR=92.663 IKR=0.099989 ISC=1e-13
+NC=1.9989 RB=9.92568 IRB=0.198899 RBM=9.92561
+RE=0.100034 RC=0.998278 XTB=0.498188 XTI=2.99897 EG=1.11183
+CJE=2.48923e-10 VJE=0.95 MJE=0.23 TF=1e-09
+XTF=1 VTF=10 ITF=0.01 CJC=0
+VJC=0.95 MJC=0.23 XCJC=0.9 FC=0.5
+TR=1e-07 PTF=0 KF=0 AF=1
.ENDS
Rshunt_1 1 0 1e12
Rshunt_2 2 0 1e12
Rshunt_5 5 0 1e12
Rshunt_4 4 0 1e12
Rshunt_6 6 0 1e12
Rshunt_VCC VCC 0 1e12
Rshunt_3 3 0 1e12
