* Design31 (converted from Multisim)
vV1 1 4 dc 0 ac 1 0
+      distof1 0 0
+      distof2 0 0
+      sin(0 169.70562744 60 0 0 0)

* * !!!BEGIN-INTERACT
*  : delay_factor ++++i2 ;
*  : max_prim_volt ++++f4 ;
*  : max_prim_cur  ++++f6 ;
*  : max_sec_volt ++++f8 ;
*  : max_sec_cur ++++f10 ;
*  : max_out_kva ++++f12 ;
*  0          constant  S_OK
*  1e30       constant  xfmr_ok
*  0          constant  xfmr_blown
*  0.0        VARIABLE  flag
*  1e30       VARIABLE  resistance
*  0          VARIABLE  cnt
*  1          VARIABLE  delaytime
*  0          VARIABLE  S_BLOWN
*  0.0        VARIABLE  prim_volt
*  0.0        VARIABLE  prim_cur
*  0.0        VARIABLE  sec_volt
*  0.0        VARIABLE  sec_cur
*  0.0        VARIABLE  sec_kva
*  0.0        VARIABLE  kva_out
*
* : DELAY
*  *delaytime  0 do
*          *cnt 1+ ==>_*cnt
*          *cnt *delaytime =  if
*          *S_BLOWN 1
* + ==>_*S_BLOWN
*          0 ==>_*cnt
*          endif
*   loop
*   *S_BLOWN ==>_*animation_state
* ;
*
* : RESET
*       delay_factor 10000 * ==>_*delaytime
*       0.0 ==>_*flag
*       0.0 ==>_*resistance
*       0.0 ==>_*prim_volt
*       0.0 ==>_*sec_volt
*       0.0 ==>_*prim_cur
*       0.0 ==>_*sec_cur
*       0.0 ==>_*sec_kva
*       0.0 ==>_*kva_out
*       xfmr_ok  resistance   GRADUAL_CHANGE_AT_RUN
*       S_OK   ==>_*animation_state
*       0 ==>_*S_BLOWN
* ;
*
*  :BEGIN_PLOT
*         RESET
*  ;
*
*  : XFMR_BLOWN
*      xfmr_blown  resistance   GRADUAL_CHANGE_AT_RUN
*  ;
*
*  :GRADUAL_CHANGE_AT_RUN locals| ref value |
*     value     SET_INSTANCE Resistor ::R Rblwn resistance
*  ;
*
*  :OUT_DATA
*   1.0 *flag f.> if
*     GET_INSTANCE Resistor ::R Rprmry i ==>_*prim_volt
*     GET_INSTANCE Resistor ::R Rsec  i  ==>_*sec_volt
*     GET_INSTANCE Resistor ::R Rs1  i  ==>_*prim_cur
*     GET_INSTANCE Resistor ::R Rs2  i  ==>_*sec_cur
*     *prim_volt f.abs 0.707 f.* ==>_*prim_volt
*     *sec_volt f.abs 0.707 f.* ==>_*sec_volt
*     *prim_cur f.abs 0.707 f.* ==>_*prim_cur
*     *sec_cur f.abs 0.707 f.* ==>_*sec_cur
*     *sec_volt *sec_cur f.* ==>_*sec_kva
*     *sec_kva 1.0e3 f./ ==>_*kva_out
*     max_prim_volt *prim_volt f.< if
*          1.0 ==>_*flag
*          DELAY
*          DELAY
*          DELAY
*          DELAY
*          XFMR_BLOWN
*     else max_prim_cur *prim_cur f.< if
*          1.0 ==>_*flag
*          DELAY
*          DELAY
*          DELAY
*          DELAY
*          XFMR_BLOWN
*     else max_sec_volt *sec_volt f.< if
*          1.0 ==>_*flag
*          4 ==>_*S_BLOWN
*          DELAY
*          DELAY
*          DELAY
*          DELAY
*          XFMR_BLOWN
*     else max_sec_cur *sec_cur f.< if
*          1.0 ==>_*flag
*          4 ==>_*S_BLOWN
*          DELAY
*          DELAY
*          DELAY
*          DELAY
*          XFMR_BLOWN
*     else max_out_kva *kva_out f.< if
*          1.0 ==>_*flag
*          4 ==>_*S_BLOWN
*          DELAY
*          DELAY
*          DELAY
*          DELAY
*          XFMR_BLOWN
*     endif endif endif endif endif
*   endif
*  ;
*
* :BEGIN_ANALYSIS
*     RESET
* ;
*
* !!!END-INTERACT
xU1 1 4 3 0 XFMR2U1
.SUBCKT XFMR2U1 1 2 3 4
*  *1, 2-- primary winding,  *3,4-- secondary terminal
Rblwn 1 2 1e30
Rs1 1 11 1
Rs2 31 3 1
L1  11 2 5.0005
L2  31 4 1.250125
K12  L1 L2 0.9999000099990001
Bprmry 50 0 v={v(1)-v(2)}
Bsec 51 0 v={v(3)-v(4)}
Rprmry 50 0 1
Rsec 51 0 1
.ENDS

dD1 3 5 D1N4007_VSH

rR1 5 0 1k vresR1
.model vresR1 r(  )

* scope XSC1
.model D1N4007_VSH d is = 1.43733E-008 n = 1.80829 rs = 0.0414712
+ eg = 1.11 xti = 3 tnom = 27
+ cjo = 2.8119E-011 vj = 0.700053 m = 0.346714 fc = 0.5
+ tt = 4.10886E-006 bv = 1100 ibv = 10 af = 1 kf = 0
Rshunt_1 1 0 1e12
Rshunt_4 4 0 1e12
Rshunt_3 3 0 1e12
Rshunt_5 5 0 1e12
