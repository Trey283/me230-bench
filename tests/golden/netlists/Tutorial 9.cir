* Tutorial 9 (converted from Multisim)
cC1 2 1 4.7u

cC2 3 0 1.5u

rR1 1 0 470 vresR1
.model vresR1 r(  )

lL1 1 3 650m

vV1 2 0 dc 0 ac 120 0
+      distof1 0 0
+      distof2 0 0
+      sin(0 169.68 60 0 0 0)

Rshunt_2 2 0 1e12
Rshunt_1 1 0 1e12
Rshunt_3 3 0 1e12
