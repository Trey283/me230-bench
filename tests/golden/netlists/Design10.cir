* Design10 (converted from Multisim)
rR1 1 2 350 vresR1
.model vresR1 r(  )

cC1 0 2 1u

* * !!!BEGIN-INTERACT
*  2.0 constant high
*  0.0 constant low
*  2   constant max_states
*  low VARIABLE volt
*
*  :MAP_KEYBOARD_INPUT ++++K1 1 ++++k1 -1 ;
*
*  : UPDATE_SETTINGS
*     *animation_state max_states  low  high  STATE  volt
*     GRADUAL_CHANGE_AT_RUN
*  ;
*
*  :KEYBOARD_INPUT locals| shift_state |
*     shift_state *animation_state max_states NEXT_STATE_WRAP
*                                             ==>_*animation_state
*     UPDATE_SETTINGS
*  ;
*
*  :GRADUAL_CHANGE_AT_RUN locals| ref value |
*     value  SET_INSTANCE Vsource ::V  V2 dc
*  ;
*
*  : INIT_IMOUSE_OPTION
*    1 0 4 IMOUSE_SET
*  ;
*
*  : GET_IMOUSE_SUBCOMPS ( -- [iIdxN ... iIdx1] )
*    1
*  ;
*
*  : ON_SUBCOMP_IMOUSE_EVENT locals| eEventType nOptions iSubCompIdx |
*    eEventType 2 = if
*      -1
*      -1 KEYBOARD_INPUT
*    else
*      0
*    endif
*  ;
*
*  ( Initialize the settings )
*   UPDATE_SETTINGS
*   INIT_IMOUSE_OPTION
*
*  :BEGIN_PLOT
*     UPDATE_SETTINGS
*  ;
*
*  :BEGIN_ANALYSIS
*    UPDATE_SETTINGS
*  ;
*
* !!!END-INTERACT

xS1 1 3   SwitchS1

.subckt SwitchS1 1 2
V2 5 0 DC 0
R1 5 6 20
V1 6 0 DC 0
W0 2 1 V1 NC_contact
.model NC_contact csw(it=0.0375 ih=0.0125 ron=1e-8 roff=1e+30)
.ENDS

XFG1 nc_XFG1_3 0 3 XXFG1_225007384

* scope XSC2
.subckt XXFG1_225007384 1 2 3
vfgen_src_positive 3 2 dc 2.000000e+00 ac 2.000000000000000000e+00 pulse(0.000000000000000000e+00 4.000000000000000000e+00 0 1.000000000000000021e-08 1.000000000000000021e-08 8.333323333333333277e-03 1.666666666666666644e-02)
vfgen_src_negative 2 1 dc 2.000000e+00 ac 2.000000000000000000e+00 pulse(0.000000000000000000e+00 4.000000000000000000e+00 0 1.000000000000000021e-08 1.000000000000000021e-08 8.333323333333333277e-03 1.666666666666666644e-02)
.ends
Rshunt_1 1 0 1e12
Rshunt_2 2 0 1e12
Rshunt_3 3 0 1e12
Rshunt_nc_XFG1_3 nc_XFG1_3 0 1e12
