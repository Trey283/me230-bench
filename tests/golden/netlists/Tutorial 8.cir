* Tutorial 8 (converted from Multisim)
vV1 1 0 dc 0 ac 12 159.2m
+      distof1 0 0
+      distof2 0 0
+      sin(0 12 159.2m 0 0 0)

rR1 3 0 16 vresR1
.model vresR1 r(  )

rR2 2 1 4 vresR2
.model vresR2 r(  )

xZ1 2 3 Zload_indZ1
.SUBCKT Zload_indZ1 1 2
R1 1 3 1e-3
L1 3 2 19.994339581798243
.ends

xZ2 4 0 Zload_indZ2
.SUBCKT Zload_indZ2 1 2
R1 1 3 1e-3
L1 3 2 24.992924477247804
.ends

xZ3 3 4 Zload_capZ3
.SUBCKT Zload_capZ3 1 2
R1 1 3 1e-3
C1 3 2 0.07140835564927944
.ends

Rshunt_1 1 0 1e12
Rshunt_3 3 0 1e12
Rshunt_2 2 0 1e12
Rshunt_4 4 0 1e12
