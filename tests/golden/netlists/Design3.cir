* Design3 (converted from Multisim)
iI1 5 1 dc 2 ac 0 0
+           distof1 0 0
+           distof2 0 0

rR1 2 5 2k vresR1
.model vresR1 r(  )

rR2 2 5 3k vresR2
.model vresR2 r(  )

rR3 2 1 800 vresR3
.model vresR3 r(  )

rR4 1 5 10k vresR4
.model vresR4 r(  )

rR5 1 3 4k vresR5
.model vresR5 r(  )

rR6 1 3 6k vresR6
.model vresR6 r(  )

rR7 3 5 2.61k vresR7
.model vresR7 r(  )

iI2 0 6 dc 2 ac 0 0
+           distof1 0 0
+           distof2 0 0

rR8 4 0 2k vresR8
.model vresR8 r(  )

rR9 7 0 10k vresR9
.model vresR9 r(  )

rR10 8 0 5k vresR10
.model vresR10 r(  )

* * !!!BEGIN-INTERACT
*
*  ( External state variables )
*  1e-12  constant  low
*  : Rshunt              ++++f1 ;
*  : Mode                 ++++i3 ;
*
*  ( Internal state variables )
*  0.0      VARIABLE   r1Cur
*  0         VARIABLE   nTime
*  0         VARIABLE   nTimeCur
*
*  high  VARIABLE r1_resistance
*
*
* .( Loading the ammeter.. )  cr
*
*  :  RESET
*       0.0  VALUE  SET_ANIMATION_TEXT
*       Rshunt  SET_INSTANCE Resistor ::R r1 resistance
*       1   RESET_ACDC
*       GET_LOCAL_TIME   ==>_*nTime
*  ;
*
*  :BEGIN_PLOT
*    RESET
*  ;
*
*  :OUT_DATA
*   (( GET_INSTANCE Resistor ::R r1 i  ))  1 ADD_ACDC
*   GET_LOCAL_TIME   ==>_*nTimeCur
*   *nTimeCur *nTime - 2 >= if
*   ((if Mode 1 GET_AC 1 GET_DC ))if   VALUE  SET_ANIMATION_TEXT
*   *nTimeCur  ==>_*nTime
*  endif
*  ;
*
* :  BEGIN_ANALYSIS
*        RESET
*    ;
*     1  ACDC::ALLOC_INDEX
*
* :SIMULATION_CHANGED
*    ACDC::CIRCUIT_CHANGE
*    GET_LOCAL_TIME   ==>_*nTime
* ;
*
* !!!END-INTERACT

xU1 6 4  AmmeterU1

.subckt AmmeterU1 1 2
Vam 1 2 dc 0
.ends

* * !!!BEGIN-INTERACT
*
*  ( External state variables )
*  1e-12  constant  low
*  : Rshunt              ++++f1 ;
*  : Mode                 ++++i3 ;
*
*  ( Internal state variables )
*  0.0      VARIABLE   r1Cur
*  0         VARIABLE   nTime
*  0         VARIABLE   nTimeCur
*
*  high  VARIABLE r1_resistance
*
*
* .( Loading the ammeter.. )  cr
*
*  :  RESET
*       0.0  VALUE  SET_ANIMATION_TEXT
*       Rshunt  SET_INSTANCE Resistor ::R r1 resistance
*       1   RESET_ACDC
*       GET_LOCAL_TIME   ==>_*nTime
*  ;
*
*  :BEGIN_PLOT
*    RESET
*  ;
*
*  :OUT_DATA
*   (( GET_INSTANCE Resistor ::R r1 i  ))  1 ADD_ACDC
*   GET_LOCAL_TIME   ==>_*nTimeCur
*   *nTimeCur *nTime - 2 >= if
*   ((if Mode 1 GET_AC 1 GET_DC ))if   VALUE  SET_ANIMATION_TEXT
*   *nTimeCur  ==>_*nTime
*  endif
*  ;
*
* :  BEGIN_ANALYSIS
*        RESET
*    ;
*     1  ACDC::ALLOC_INDEX
*
* :SIMULATION_CHANGED
*    ACDC::CIRCUIT_CHANGE
*    GET_LOCAL_TIME   ==>_*nTime
* ;
*
* !!!END-INTERACT

xU2 6 7  AmmeterU2

.subckt AmmeterU2 1 2
Vam 1 2 dc 0
.ends

* * !!!BEGIN-INTERACT
*
*  ( External state variables )
*  1e-12  constant  low
*  : Rshunt              ++++f1 ;
*  : Mode                 ++++i3 ;
*
*  ( Internal state variables )
*  0.0      VARIABLE   r1Cur
*  0         VARIABLE   nTime
*  0         VARIABLE   nTimeCur
*
*  high  VARIABLE r1_resistance
*
*
* .( Loading the ammeter.. )  cr
*
*  :  RESET
*       0.0  VALUE  SET_ANIMATION_TEXT
*       Rshunt  SET_INSTANCE Resistor ::R r1 resistance
*       1   RESET_ACDC
*       GET_LOCAL_TIME   ==>_*nTime
*  ;
*
*  :BEGIN_PLOT
*    RESET
*  ;
*
*  :OUT_DATA
*   (( GET_INSTANCE Resistor ::R r1 i  ))  1 ADD_ACDC
*   GET_LOCAL_TIME   ==>_*nTimeCur
*   *nTimeCur *nTime - 2 >= if
*   ((if Mode 1 GET_AC 1 GET_DC ))if   VALUE  SET_ANIMATION_TEXT
*   *nTimeCur  ==>_*nTime
*  endif
*  ;
*
* :  BEGIN_ANALYSIS
*        RESET
*    ;
*     1  ACDC::ALLOC_INDEX
*
* :SIMULATION_CHANGED
*    ACDC::CIRCUIT_CHANGE
*    GET_LOCAL_TIME   ==>_*nTime
* ;
*
* !!!END-INTERACT

xU3 6 8  AmmeterU3

.subckt AmmeterU3 1 2
Vam 1 2 dc 0
.ends

Rshunt_5 5 0 1e12
Rshunt_1 1 0 1e12
Rshunt_2 2 0 1e12
Rshunt_3 3 0 1e12
Rshunt_6 6 0 1e12
Rshunt_4 4 0 1e12
Rshunt_7 7 0 1e12
Rshunt_8 8 0 1e12
