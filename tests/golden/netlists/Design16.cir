* Design16 (converted from Multisim)
XFG1 0 nc_XFG1_2 2 XXFG1_129721184

dD1 4 1 D1N4007_ON

dD2 1 3 D1N4007_ON

rR1 2 1 1k vresR1
.model vresR1 r(  )

rR2 1 0 10k vresR2
.model vresR2 r(  )

vV1 3 0 dc 0 ac 0 0
+           distof1 0 0
+           distof2 0 0

vV2 0 4 dc 0 ac 0 0
+           distof1 0 0
+           distof2 0 0

* scope XSC1
.subckt XXFG1_129721184 1 2 3
vfgen_src_positive 3 2 dc 0.000000e+00 ac 2.000000000000000000e+00 sin(0.000000000000000000e+00 2.000000000000000000e+00 1.000000000000000000e+03 0)
vfgen_src_negative 2 1 dc 0.000000e+00 ac 2.000000000000000000e+00 sin(0.000000000000000000e+00 2.000000000000000000e+00 1.000000000000000000e+03 0)
.ends
.MODEL D1N4007_ON d
+IS=7.02767e-09 RS=0.0341512 N=1.80803 EG=1.05743
+XTI=5 BV=1000 IBV=5e-08 CJO=1e-11
+VJ=0.7 M=0.5 FC=0.5 TT=1e-07
+KF=0 AF=1
Rshunt_nc_XFG1_2 nc_XFG1_2 0 1e12
Rshunt_2 2 0 1e12
Rshunt_4 4 0 1e12
Rshunt_1 1 0 1e12
Rshunt_3 3 0 1e12
