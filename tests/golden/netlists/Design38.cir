* Design38 (converted from Multisim)
vV1 2 0 dc 12 ac 0 0
+           distof1 0 0
+           distof2 0 0

dD1 1 2 D1N4007_VSH

rR1 1 0 1k vresR1
.model vresR1 r(  )

.model D1N4007_VSH d is = 1.43733E-008 n = 1.80829 rs = 0.0414712
+ eg = 1.11 xti = 3 tnom = 27
+ cjo = 2.8119E-011 vj = 0.700053 m = 0.346714 fc = 0.5
+ tt = 4.10886E-006 bv = 1100 ibv = 10 af = 1 kf = 0
Rshunt_2 2 0 1e12
Rshunt_1 1 0 1e12
