* Tutorial 10 (converted from Multisim)
rR1 2 1 4 vresR1
.model vresR1 r(  )

rR2 3 0 2 vresR2
.model vresR2 r(  )

cC1 3 0 100m

lL1 1 0 400m

vV1 2 0 dc 0 ac 75 0
+      distof1 0 0
+      distof2 0 0
+      sin(0 106.05 1.592 0 0 0)

vV2 1 3 dc 0 ac 100 60
+      distof1 0 0
+      distof2 0 0
+      sin(0 141.4 1.592 0 0 0)

Rshunt_2 2 0 1e12
Rshunt_1 1 0 1e12
Rshunt_3 3 0 1e12
