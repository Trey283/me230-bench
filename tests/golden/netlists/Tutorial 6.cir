* Tutorial 6 (converted from Multisim)
lL1 1 2 200m

vV1 1 0 dc 0 ac 1 0
+      distof1 0 0
+      distof2 0 0
+      sin(0 169.68 60 0 0 0)

rR1 3 0 100 vresR1
.model vresR1 r(  )

cC1 2 3 20u

Rshunt_1 1 0 1e12
Rshunt_2 2 0 1e12
Rshunt_3 3 0 1e12
