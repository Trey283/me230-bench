* Tutorial 5 (converted from Multisim)
rR1 1 2 150 vresR1
.model vresR1 r(  )

lL1 2 0 750m

* scope XSC1
iI1 0 1 dc 0 ac 0.77 0
+      distof1 0 0
+      distof2 0 0
+      sin(0 0.77 55 0 0 0)

Rshunt_1 1 0 1e12
Rshunt_2 2 0 1e12
