* Design29 (converted from Multisim)
vV1 4 0 dc 5 ac 0 0
+           distof1 0 0
+           distof2 0 0

vV2 7 0 dc 12 ac 0 0
+           distof1 0 0
+           distof2 0 0

rR1 1 2 100 vresR1
.model vresR1 r(  )

rR2 6 7 550 vresR2
.model vresR2 r(  )

xU1_a 3 0 5 0 MCT6

* * !!!BEGIN-INTERACT
*  2.0 constant high
*  0.0 constant low
*  2   constant max_states
*  low VARIABLE volt
*
*  :MAP_KEYBOARD_INPUT ++++K1 1 ++++k1 -1 ;
*
*  : UPDATE_SETTINGS
*     *animation_state max_states  low  high  STATE  volt
*     GRADUAL_CHANGE_AT_RUN
*  ;
*
*  :KEYBOARD_INPUT locals| shift_state |
*     shift_state *animation_state max_states NEXT_STATE_WRAP
*                                             ==>_*animation_state
*     UPDATE_SETTINGS
*  ;
*
*  :GRADUAL_CHANGE_AT_RUN locals| ref value |
*     value  SET_INSTANCE Vsource ::V  V2 dc
*  ;
*
*  : INIT_IMOUSE_OPTION
*    1 0 4 IMOUSE_SET
*  ;
*
*  : GET_IMOUSE_SUBCOMPS ( -- [iIdxN ... iIdx1] )
*    1
*  ;
*
*  : ON_SUBCOMP_IMOUSE_EVENT locals| eEventType nOptions iSubCompIdx |
*    eEventType 2 = if
*      -1
*      -1 KEYBOARD_INPUT
*    else
*      0
*    endif
*  ;
*
*  ( Initialize the settings )
*   UPDATE_SETTINGS
*   INIT_IMOUSE_OPTION
*
*  :BEGIN_PLOT
*     UPDATE_SETTINGS
*  ;
*
*  :BEGIN_ANALYSIS
*    UPDATE_SETTINGS
*  ;
*
* !!!END-INTERACT

xS1 1 4   SwitchS1 Params: Ron=100u Roff=100Meg

.subckt SwitchS1 1 2 Params: Ron=1e-8 Roff=1e30
V2 5 0 DC 0
R1 5 6 20
V1 6 0 DC 0
W0 2 1 V1 NC_contact
.model NC_contact csw(it=0.0375 ih=0.0125 ron=1 roff=1000000000000)
.ENDS

** !!!BEGIN-INTERACT
*  : Ion           ++++f2    ;
*  0.0      VARIABLE   r1Cur
*
*  : LED_OFF
*     1 11 0 SET_SUBCOMP_PRP
*     0 13 0 SET_SUBCOMP_PRP
*     1 12 0 SET_SUBCOMP_PRP
*     0 14 0 SET_SUBCOMP_PRP
*  ;
*
*  : LED_ON
*     0 11 0 SET_SUBCOMP_PRP
*     1 13 0 SET_SUBCOMP_PRP
*     0 12 0 SET_SUBCOMP_PRP
*     1 14 0 SET_SUBCOMP_PRP
*  ;
*
*  :UPDATE_SETTINGS
*     LED_OFF
*  ;
*
*  :OUT_DATA
*     GET_INSTANCE Vsource ::V V  i  ==>_*r1Cur
*     Ion  *r1Cur  0.00004999  f.-   f.<=   if
*        LED_ON
*     else
*        LED_OFF
*     endif
*  ;
*
*  :BEGIN_PLOT
*     LED_OFF
*  ;
*
* !!!END-INTERACT
*
xLED1 2 3 LED_redLED1
*
.SUBCKT LED_redLED1  K A
D1 1 A  LED_mod
V   K  1  DC 0
.MODEL LED_mod D (
+ IS=1.024e-017 N=2.005e+000 RS=2.342e-003
+ BV=6.100e+001 IBV=6.000e-006
+ EG=1.110e+000 XTI=3.000e+000
+ CJO=3.238e-011, M=3.388e-001 VJ=3.250e-001
+ FC=5.000e-001 KF=0.000e+000 AF=1.000e+000 )
.ENDS

** !!!BEGIN-INTERACT
*  : Ion           ++++f2    ;
*  0.0      VARIABLE   r1Cur
*
*  : LED_OFF
*     1 11 0 SET_SUBCOMP_PRP
*     0 13 0 SET_SUBCOMP_PRP
*     1 12 0 SET_SUBCOMP_PRP
*     0 14 0 SET_SUBCOMP_PRP
*  ;
*
*  : LED_ON
*     0 11 0 SET_SUBCOMP_PRP
*     1 13 0 SET_SUBCOMP_PRP
*     0 12 0 SET_SUBCOMP_PRP
*     1 14 0 SET_SUBCOMP_PRP
*  ;
*
*  :UPDATE_SETTINGS
*     LED_OFF
*  ;
*
*  :OUT_DATA
*     GET_INSTANCE Vsource ::V V  i  ==>_*r1Cur
*     Ion  *r1Cur  0.00004999  f.-   f.<=   if
*        LED_ON
*     else
*        LED_OFF
*     endif
*  ;
*
*  :BEGIN_PLOT
*     LED_OFF
*  ;
*
* !!!END-INTERACT
*
xLED2 6 5 LED_redLED2
*
.SUBCKT LED_redLED2  K A
D1 1 A  LED_mod
V   K  1  DC 0
.MODEL LED_mod D (
+ IS=1.024e-017 N=2.005e+000 RS=2.342e-003
+ BV=6.100e+001 IBV=6.000e-006
+ EG=1.110e+000 XTI=3.000e+000
+ CJO=3.238e-011, M=3.388e-001 VJ=3.250e-001
+ FC=5.000e-001 KF=0.000e+000 AF=1.000e+000 )
.ENDS

* scope XSC1
.SUBCKT MCT6 1 2 3 5
*      Model Generated by MODPEX     *
*Copyright(c) Symmetry Design Systems*
*         All Rights Reserved        *
*    UNPUBLISHED LICENSED SOFTWARE   *
*   Contains Proprietary Information *
*      Which is The Property of      *
*     SYMMETRY OR ITS LICENSORS      *
*Commercial Use or Resale Restricted *
*   by Symmetry License Agreement    *
* Model generated on Sep  8, 97
* MODEL FORMAT: SPICE3
* Optocoupler macro model
* External node designations
* Node 1 -> DA
* Node 2 -> DK
* Node 3 -> QC
* Node 4 -> QB
* Node 5 -> QE
DIN 1 6 dmodel
VT 6 2 0
CIO 1 3 1e-12
QOUT 3 4 5 qmodel
RFX 5 4 1e9
BFX 5 4 I=0+0.000946774*I(VT)+1.20744*I(VT)*I(VT)
* Default values used in dmodel:
*   TT=0 BV=infinite
.MODEL dmodel d
+IS=1.71583e-12 RS=1.65526 N=1.97764 XTI=4
+EG=1.52495 CJO=1.80001e-11 VJ=0.75 M=0.5 FC=0.5
.MODEL qmodel npn
+IS=1e-09 BF=1000 NF=1.00948 VAF=77.4232
+IKF=0.0180931 ISE=1e-08 NE=3.36172 BR=0.1
+NR=1.5 VAR=1.09778 IKR=0.180931 ISC=9.99233e-14
+NC=2.00276 RB=10 IRB=0.2 RBM=10
+RE=4.5755 RC=100 XTB=0.1 XTI=2.76389 EG=0.1
+CJE=9.7676e-12 VJE=0.4 MJE=0.180467 TF=1.00004e-09
+XTF=1 VTF=10 ITF=0.01 CJC=1.96601e-11
+VJC=0.593953 MJC=0.415331 XCJC=0.9 FC=0.5
+TR=1e-07 PTF=0 KF=0 AF=1
.ENDS MCT6
Rshunt_4 4 0 1e12
Rshunt_7 7 0 1e12
Rshunt_1 1 0 1e12
Rshunt_2 2 0 1e12
Rshunt_6 6 0 1e12
Rshunt_3 3 0 1e12
Rshunt_5 5 0 1e12
