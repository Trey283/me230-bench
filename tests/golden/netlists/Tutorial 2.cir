* Tutorial 2 (converted from Multisim)
vV1 1 0 dc 10 ac 0 0
+           distof1 0 0
+           distof2 0 0

rR1 1 5 1 vresR1
.model vresR1 r(  )

rR2 5 3 1 vresR2
.model vresR2 r(  )

rR3 5 0 2 vresR3
.model vresR3 r(  )

rR4 3 0 3 vresR4
.model vresR4 r(  )

gI1 1 3 5 0 4

XMM2 1 5 XXMM2

XMM3 5 3 XXMM4

XMM4 5 0 XXMM4

.subckt XXMM2 2 1
I_multi_meter 1 2 DC 0.000000e+00
R_multi_meter 2 1 1.000000e+09
.ends
.subckt XXMM4 2 1
I_multi_meter 1 2 DC 0.000000e+00
R_multi_meter 2 1 1.000000e+09
.ends
Rshunt_1 1 0 1e12
Rshunt_5 5 0 1e12
Rshunt_3 3 0 1e12
