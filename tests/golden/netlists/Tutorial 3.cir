* Tutorial 3 (converted from Multisim)
rR1 1 5 2 vresR1
.model vresR1 r(  )

rR2 5 6 2 vresR2
.model vresR2 r(  )

rR3 1 6 2 vresR3
.model vresR3 r(  )

rR4 5 4 10 vresR4
.model vresR4 r(  )

rR5 1 0 4 vresR5
.model vresR5 r(  )

rR6 6 0 4 vresR6
.model vresR6 r(  )

vV1 4 0 dc 6 ac 0 0
+           distof1 0 0
+           distof2 0 0

iI1 0 6 dc 3 ac 0 0
+           distof1 0 0
+           distof2 0 0

XMM1 0 6 XXMM1_231338128

.subckt XXMM1_231338128 2 1
I_multi_meter 1 2 DC 0.000000e+00
R_multi_meter 2 1 1.000000e+09
.ends
Rshunt_1 1 0 1e12
Rshunt_5 5 0 1e12
Rshunt_6 6 0 1e12
Rshunt_4 4 0 1e12
